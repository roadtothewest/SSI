* INA333 solo
.include ../models/INA333.LIB
VCC VCC 0 3.3
VR VREF 0 1.65
Vp P VREF AC 0.5
Vn N VREF AC -0.5
X1 P N VCC 0 OUT VREF RGP RGN INA333
RG RGP RGN 5.22k
.op
.ac dec 10 1 100k
.meas ac g find mag(V(out)) at=100
.end
