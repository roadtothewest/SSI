* T4 - Rechazo de 50 Hz de modo comun en los 4 canales: sensado del RLD y RLD con/sin
* Red 311 Vpk acoplada al cuerpo; los 4 canales sin senal. Salidas referidas a la entrada (RTI).
* CASE 0: sin RLD, referencia pasiva directa a VREF (1 ohm), sin R de sensado
* CASE 1: RLD, sensado en punto medio de RG (604k x4, Cint 1n)
* CASE 2: RLD, sensado 100k x8 sobre electrodos (pizarra), Cint 12n (misma R*C que el caso 1)
* CASE 3: sin RLD (ref. directa), con los 100k x8 conectados: solo el efecto de carga
* CASE 4: sin RLD, referencia pasiva a VREF por 390k (misma R de seguridad que el RLD)
* CGE: 20p = a bateria (flotante), 1 = circuito unido a tierra de red
.include opa.lib
.include ina.lib
.step param CASE list 0 1 2 3 4
.step param CGE list 20p 1
.param SENSE={if(CASE==1,0,if(CASE==2|CASE==3,1,-1))}
.param RLDMODE={if(CASE==1|CASE==2,2,if(CASE==4,1,0))}
.param CINT={if(SENSE==1,12n,1n)}
.param RLIM=390k RS=100k CCM=47p CD=100p
.param VMAINS_TRAN=0 VMAINS_AC=311
VIN1 S1 BODY 0
VIN2 S2 BODY 0
VIN3 S3 BODY 0
VIN4 S4 BODY 0
.include afe_4ch_top.inc
.ac list 50
* RTI = |V(adc)| / 503.3 (ganancia de la cadena a 50 Hz ~ 0.99 x 508; se usa 503.3 de referencia)
.meas ac a1 find mag(V(adc1)) at=50
.meas ac a2 find mag(V(adc2)) at=50
.meas ac a3 find mag(V(adc3)) at=50
.meas ac a4 find mag(V(adc4)) at=50
.meas ac rti1_uVpk param mag(a1)/503.3*1e6
.meas ac rti2_uVpk param mag(a2)/503.3*1e6
.meas ac rti3_uVpk param mag(a3)/503.3*1e6
.meas ac rti4_uVpk param mag(a4)/503.3*1e6
.meas ac vcm find mag(V(body)-V(vref)) at=50
.save V(adc1) V(adc2) V(adc3) V(adc4) V(body) V(vref)
.options gmin=100f gminsteps=0 srcsteps=0
.end
