* T7 - Prueba funcional: senoidal + ruido en los 4 canales (banco completo, RLD activo)
* Entrada diferencial de cada canal = senoidal (f distinta por canal) + ruido:
*   - artefacto de movimiento / deriva 0.1-10 Hz, RMS NLF   (noise/lf_chK.pwl)
*   - ruido blanco gaussiano hasta ~8 kHz, RMS NWH          (noise/wh_chK.pwl)
*   - ademas: media celda DC de cada electrodo y 50 Hz de red por el cuerpo (modo comun)
* La senoidal tiene RMS = NTOT/RATIO (10 o 100 veces menor que el ruido).
* CASE 0: solo senoidal (RATIO 10), sin ruido ni red -> referencia limpia
* CASE 1: senoidal + ruido, RATIO 10      CASE 2: senoidal + ruido, RATIO 100
.include opa.lib
* INA333 equivalente (ver models/ina_behav.lib): el macromodelo TI es inviable en transitorios largos
.include models/ina_behav.lib
.step param CASE list 0 1 2
.param RATIO={if(CASE==2,100,10)} KN={if(CASE==0,0,1)}
.param NLF=1m NWH=300u NTOT={sqrt(NLF**2+NWH**2)}
.param AS={NTOT*sqrt(2)/RATIO}
.param F1=73 F2=131 F3=211 F4=307
.param RLDMODE=2 SENSE=0 CINT=1n RLIM=390k RS=100k CCM=47p CD=100p
.param CGE=1 VMAINS_TRAN={if(CASE==0,0,311)} VMAINS_AC=0
VL1 nl1 0 PWL file=noise/lf_ch1.pwl
VL2 nl2 0 PWL file=noise/lf_ch2.pwl
VL3 nl3 0 PWL file=noise/lf_ch3.pwl
VL4 nl4 0 PWL file=noise/lf_ch4.pwl
VW1 nw1 0 PWL file=noise/wh_ch1.pwl
VW2 nw2 0 PWL file=noise/wh_ch2.pwl
VW3 nw3 0 PWL file=noise/wh_ch3.pwl
VW4 nw4 0 PWL file=noise/wh_ch4.pwl
BIN1 S1 BODY V={AS}*sin(2*pi*{F1}*time) + {KN}*({NLF}*V(nl1)+{NWH}*V(nw1))
BIN2 S2 BODY V={AS}*sin(2*pi*{F2}*time) + {KN}*({NLF}*V(nl2)+{NWH}*V(nw2))
BIN3 S3 BODY V={AS}*sin(2*pi*{F3}*time) + {KN}*({NLF}*V(nl3)+{NWH}*V(nw3))
BIN4 S4 BODY V={AS}*sin(2*pi*{F4}*time) + {KN}*({NLF}*V(nl4)+{NWH}*V(nw4))
* sondas de la entrada diferencial (referidas a tierra para guardarlas con precision)
BD1 d1 0 V=V(S1)-V(BODY)
BD2 d2 0 V=V(S2)-V(BODY)
BD3 d3 0 V=V(S3)-V(BODY)
BD4 d4 0 V=V(S4)-V(BODY)
.include afe_4ch_top.inc
.tran 0 1.25 0 50u
.save V(d1) V(d2) V(d3) V(d4) V(adc1) V(adc2) V(adc3) V(adc4) V(body) V(vref) V(rldo) V(xch1:g2o) V(ina1)
.options gmin=100f plotwinsize=0 numdgt=15
.end
