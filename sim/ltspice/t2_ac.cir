* T2 - Respuesta en frecuencia de los 4 canales (banco completo: 9 electrodos, RLD activo, a bateria)
* DRV 0: 1 V AC diferencial en los 4 canales a la vez -> respuesta de cada canal
* DRV 1: 1 V AC solo en CH1 -> diafonia hacia CH2..CH4
.include opa.lib
.include ina.lib
.param RLDMODE=2 SENSE=0 CINT=1n RLIM=390k CGE=20p RS=100k CCM=47p CD=100p
.param VMAINS_TRAN=0 VMAINS_AC=0
.step param DRV list 0 1
VIN1 S1 BODY AC 1
VIN2 S2 BODY AC {if(DRV==0,1,0)}
VIN3 S3 BODY AC {if(DRV==0,1,0)}
VIN4 S4 BODY AC {if(DRV==0,1,0)}
.include afe_4ch_top.inc
.ac dec 50 0.1 100k
.meas ac G100_1 find mag(V(adc1)) at=100
.meas ac G100_2 find mag(V(adc2)) at=100
.meas ac G100_3 find mag(V(adc3)) at=100
.meas ac G100_4 find mag(V(adc4)) at=100
.meas ac Gmax1 max mag(V(adc1)) from=1 to=10k
.meas ac fL1 when mag(V(adc1))=Gmax1/sqrt(2) rise=1
.meas ac fH1 when mag(V(adc1))=Gmax1/sqrt(2) fall=last
.meas ac Gmax4 max mag(V(adc4)) from=1 to=10k
.meas ac fL4 when mag(V(adc4))=Gmax4/sqrt(2) rise=1
.meas ac fH4 when mag(V(adc4))=Gmax4/sqrt(2) fall=last
.save V(adc1) V(adc2) V(adc3) V(adc4) V(ina1)
.options gmin=100f
.end
