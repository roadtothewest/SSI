* T4b - Filtro RFI/proteccion: 50 Hz de modo comun vs perdida en banda (CH1, RLD en punto medio de RG)
* MODE 0: red 311 Vpk (AC), mide 50 Hz en la salida.  MODE 1: 1 V diferencial en CH1, mide ganancia.
* RFI 1: pizarra   Rs 100k, Ccm 470p, Cd 4.7n
* RFI 2: Gemini    Rs 330k, Ccm 470p, Cd 4.7n
* RFI 3: propuesta Rs 100k, Ccm 47p,  Cd 100p
* RFI 4: propuesta Rs 330k, sin Ccm,  Cd 47p
.include models/opa_behav.lib
.step param MODE list 0 1
.step param RFI list 1 2 3 4
.step param CGE list 20p 1
.param RS={if(RFI==2|RFI==4,330k,100k)}
.param CCM={if(RFI<=2,470p,if(RFI==3,47p,1f))}
.param CD={if(RFI<=2,4.7n,if(RFI==3,100p,47p))}
.param SENSE=0 RLDON=1 CINT=1n RLIM=390k RPASV=1 VSEMG=0 VMAINS_TRAN=0
.param VMAINS_AC={if(MODE==0,311,0)} VDIFF_AC={if(MODE==1,1,0)}
.include afe_4ch_top.inc
.ac list 50 100 500
.meas ac rti50_uVpk find mag(V(adc1))/503.3*1e6 at=50
.meas ac g100 find mag(V(adc1)) at=100
.meas ac g500 find mag(V(adc1)) at=500
.meas ac loss500_dB param 20*log10(mag(g500)/mag(g100))
.save V(adc1)
.options gmin=100f
.end
