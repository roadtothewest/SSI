* T5 - RLD con y sin, en frecuencia (banco de 4 canales, red 1 V AC de referencia)
* RLDMODE 0: referencia pasiva directa | 1: pasiva por 390k | 2: RLD activo
* La razon S(f) = Vcm(RLD) / Vcm(pasiva por RLIM) = 1/(1+T(f)) la calcula tools/make_figs.py.
* Pico de |S| > 6 dB indicaria margen de fase < ~30 grados.
.include opa.lib
.include ina.lib
.param SENSE=0 RS=100k CCM=47p CD=100p VMAINS_TRAN=0 VMAINS_AC=311
.step param RLDMODE list 0 1 2
.step param CINT list 470p 1n 2.2n 4.7n
.step param RLIM list 390k 1Meg
.step param CGE list 20p 1
VIN1 S1 BODY 0
VIN2 S2 BODY 0
VIN3 S3 BODY 0
VIN4 S4 BODY 0
.include afe_4ch_top.inc
.ac dec 20 1 100k
.save V(body) V(vref) V(adc1) V(adc2) V(adc3) V(adc4)
.options gmin=100f gminsteps=0 srcsteps=0
.end
